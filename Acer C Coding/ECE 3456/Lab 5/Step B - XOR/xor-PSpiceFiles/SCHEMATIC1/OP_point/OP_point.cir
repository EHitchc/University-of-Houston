** Profile: "SCHEMATIC1-OP_point"  [ c:\users\ethan\documents\ece 3456\lab 5\step b - xor\xor-PSpiceFiles\SCHEMATIC1\OP_point.sim ]

** Creating circuit file "OP_point.cir"
** WARNING: THIS AUTOMATICALLY GENERATED FILE MAY BE OVERWRITTEN BY SUBSEQUENT SIMULATIONS

*Libraries:
* Profile Libraries :
* Local Libraries :
.LIB "../../../xor-PSpiceFiles/2input nand enhancement load.lib"
.LIB "../../../xor-PSpiceFiles/2INPUT NOR ENHANCEMENT LOAD.lib"
* From [PSPICE NETLIST] section of C:\Users\Ethan\AppData\Roaming\SPB_Data\cdssetup\OrCAD_PSpice\17.2.0\PSpice.ini file:
.lib "nomd.lib"

*Analysis directives:
.OPTIONS ADVCONV
.PROBE64 V(alias(*)) I(alias(*)) W(alias(*)) D(alias(*)) NOISE(alias(*))
.INC "..\SCHEMATIC1.net"

.END
